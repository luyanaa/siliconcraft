* Canonical topology target for common/tests/magic/ls1u_mos_pair.gds.
* The Magic smoke runner independently consumes W/L from ext2spice output.
.include "../../../profiles/ls1u/models/ls1u.lib"
Xn ndrain ngate nsource vss LV1UNMOS W=2u L=2u
Xp pdrain pgate psource vdd LV1UPMOS W=2u L=2u
.end
