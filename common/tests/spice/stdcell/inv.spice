* siliconcraft inputs: A
* siliconcraft outputs: Y
* siliconcraft supplies: VDD VSS
.subckt inv A Y VDD VSS
M0 Y A VSS VSS ami06N W=1.5u L=0.6u
M1 Y A VDD VDD ami06P W=3.0u L=0.6u
.ends inv
