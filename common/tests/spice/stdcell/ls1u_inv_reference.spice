* Reference schematic for the generated LS1u INV DRC/LVS fixture.
* Device sizes mirror what the planner emits for ls1u: W is clamped to
* max(min_width_um=1.5, active_min=1.5, 1.5) = 1.5 and L to
* max(min_channel_um=0.5, poly_min=1.0) = 1.0.
M0 Y A VSS VSS LV1UNMOS W=1.5 L=1.0
M1 Y A VDD VDD LV1UPMOS W=1.5 L=1.0
.end
