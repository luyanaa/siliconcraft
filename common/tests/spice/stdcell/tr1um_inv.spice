* siliconcraft inputs: A
* siliconcraft outputs: Y
* siliconcraft supplies: VDD VSS
.subckt inv A Y VDD VSS
M0 Y A VSS VSS NMOS_mst W=3.4u L=1u
M1 Y A VDD VDD PMOS_mst W=10.2u L=1u
.ends inv
