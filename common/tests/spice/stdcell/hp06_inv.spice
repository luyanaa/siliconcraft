* siliconcraft inputs: A
* siliconcraft outputs: Y
* siliconcraft supplies: VDD VSS
.subckt inv A Y VDD VSS
M0 Y A VSS VSS hp14tbN W=1.5u L=0.6u
M1 Y A VDD VDD hp14tbP W=1.5u L=0.6u
.ends inv
