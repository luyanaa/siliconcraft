* siliconcraft inputs: A
* siliconcraft outputs: Y
* siliconcraft supplies: VDD VSS
.subckt inv A Y VDD VSS
M0 Y A VSS VSS cnm25modN W=4.5u L=3u
M1 Y A VDD VDD cnm25modP W=4.5u L=3u
.ends inv
