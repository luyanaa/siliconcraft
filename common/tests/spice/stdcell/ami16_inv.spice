* siliconcraft inputs: A
* siliconcraft outputs: Y
* siliconcraft supplies: VDD VSS
.subckt inv A Y VDD VSS
M0 Y A VSS VSS ami16N W=4u L=1.6u
M1 Y A VDD VDD ami16P W=4u L=1.6u
.ends inv
