* siliconcraft inputs: A
* siliconcraft outputs: Y
* siliconcraft supplies: VDD VSS
.subckt inv A Y VDD VSS
M0 Y A VSS VSS c35N W=1.5u L=0.4u
M1 Y A VDD VDD c35P W=1.5u L=0.4u
.ends inv
