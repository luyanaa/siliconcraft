* siliconcraft inputs: A
* siliconcraft outputs: Y
* siliconcraft supplies: VDD VSS
.subckt inv A Y VDD VSS
M0 Y A VSS VSS LV1UNMOS W=1.5u L=0.5u
M1 Y A VDD VDD LV1UPMOS W=1.5u L=0.5u
.ends inv
